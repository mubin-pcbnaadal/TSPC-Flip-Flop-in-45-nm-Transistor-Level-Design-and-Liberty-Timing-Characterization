`define VAMS_ELEC_DIS_ONLY
// This module is a kind of test board for the device under test (DUT)
// This module is written in "Verilog-AMS" language
//
// it's function is :
// - to generate electrical signals for the DUT
// - to extract measurements
// - to send measurements to the digital testbench
//
// 1/ The device under test is a TSPC D flip-flop (TSPCFF)
//
// 2/ The expected measurement is the "propagation time from CK to Q, for a rising output"
//    (cell_rise : clk rising 50% -> Q rising 50%)

`timescale 1ns/100fs

// Mandatory for  AMS
`include "constants.vams"
`include "disciplines.vams"

// The board
module board(
                        // From the testbench
                        din_logic          , // A logic signal generated by the testbench, used to generate the D input of the flip-flop
                        clk_logic          , // A logic signal generated by the testbench, used to generate the CK input of the flip-flop
                        load_capacitor_val , // The expected value of a load capacitor loading the output of the flip-flop
                        din_tt_val         , // The expected value of the transition time of the D input
                        clk_tt_val         , // The expected value of the transition time of the CK input
                        din_delay_val      , // An arbitrary incremental delay added to the D input transition
                        clk_delay_val      , // An arbitrary incremental delay added to the CK input transition
                        // To the testbench
                        cell_rise          , // The measured CK->Q propagation time for a rising output
                        dout_electrical      // The output of the dut
                        ) ;

// IO defs
input   din_logic          ;
input   clk_logic          ;
input   load_capacitor_val ;
input   din_tt_val         ;
input   clk_tt_val         ;
input   din_delay_val      ;
input   clk_delay_val      ;
output  cell_rise          ;
output  dout_electrical    ;

// Nature of the signal
wire  din_logic          ;
wire  clk_logic          ;
wreal load_capacitor_val ;
wreal din_tt_val         ;
wreal clk_tt_val         ;
wreal din_delay_val      ;
wreal clk_delay_val      ;
wreal cell_rise          ;
electrical dout_electrical ;

// Static parameters for the characterization
parameter real  power_voltage = 1.1 ; // volts
parameter real  slew_lower_threshold_pct 	= 0.3 ; // Fraction of the full swing
parameter real  slew_upper_threshold_pct 	= 0.7 ; // Fraction of the full swing
localparam real  input_threshold_pct      	= 0.5 ; // Fraction of the full swing
localparam real  output_threshold_pct      	= 0.5 ; // Fraction of the full swing

///////////////////////////////////////////////////////////////
// The analog world...
///////////////////////////////////////////////////////////////

// Internal Signals
electrical din_electrical     ; // D input of the flip-flop
electrical clk_electrical     ; // CK input of the flip-flop

// nodes for power supplies
electrical vss          ; // The ground reference
ground vss              ; // This is a global ground associated to the node "0" of the electrical simulator
electrical vdd          ; // Power supply of the device under test
electrical tmp ;

// Branches for power supplies, passive dipoles...
branch (vdd,vss) power_dut                ; //  The power supply branch is named power_dut
branch (dout_electrical,vss) load_capacitor   ; //  The passive branch for the load capacitor
branch (tmp,vss) tmp_val;

// Equations for the branches
analog
begin
 // The power_dut branch is an ideal voltage source
 V(power_dut) <+ power_voltage ;
 // The load_capacitor branch is an ideal capacitor
 // Smooth the capacitor update in order to limit simulator convergence problems
 I(load_capacitor) <+ ddt(V(load_capacitor))*transition(load_capacitor_val,0,1p,1p);
end

// Here we generate the input transitions using the variables transmitted by the testbench
// D input generator
cmos_transition cmos_tr(.din(din_logic),.dout(din_electrical),.tt_val(din_tt_val),.delay_val(din_delay_val)) ;
// CK input generator
cmos_transition cmos_clk_tr(.din(clk_logic),.dout(clk_electrical),.tt_val(clk_tt_val),.delay_val(clk_delay_val)) ;

// The device under test : the TSPC flip-flop
TSPCFF dut (.VDD(vdd),.VSS(vss),.D(din_electrical),.CK(clk_electrical),.Q(dout_electrical)) ;

///////////////////////////////////////////////////////////////
// The measurements
///////////////////////////////////////////////////////////////

///////////////////////////////////////////////////////////////
// CK -> Q propagation time for a rising output (cell_rise)
///////////////////////////////////////////////////////////////
real clk_cross_time    ; // time when CK crosses input_threshold_pct (rising edge)
real output_cross_time ; // time when Q crosses output_threshold_pct (rising edge)

// We detect the rising clock crossing input_threshold_pct (50% of VDD)
always @(cross(V(clk_electrical)-power_voltage*input_threshold_pct, +1,1e-15,1e-4 ))
   clk_cross_time = $abstime ;

// We detect the rising output crossing output_threshold_pct (50% of VDD)
always @(cross(V(dout_electrical)-power_voltage*output_threshold_pct, +1,1e-15,1e-4 ))
   output_cross_time = $abstime ;

// We compute and transmit the measured propagation time to the testbench
assign cell_rise = output_cross_time - clk_cross_time ;

endmodule
